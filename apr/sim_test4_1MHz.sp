* Test 4: FMAX Sweep @ 1.0 MHz
.param vthMP=0 vthMN=0 vthMPE=0 vthMNE=0 magRR=1 magRS=1 magCSIO=1
.include "../TR-1um/libs.tech/spice/models/models_IP62_cap_v5p1.lib"
.include "../TR-1um/libs.tech/spice/models/models_IP62_diode_v2.lib"
.include "../TR-1um/libs.tech/spice/models/models_IP62_mos_v2.lib"
.include "../TR-1um/libs.tech/spice/models/models_IP62_res_v5.lib"
.include "OSS_FRAME_sim.spice"

.options method=gear reltol=2e-3 abstol=1e-11 vntol=1e-5 itl4=40
.option klu

* Power supplies
VVDD VDD 0 5.0
VVSS VSS 0 0.0

* DUT: Full-chip extracted netlist OSS_FRAME
* Pin order: P1 P10 P11 P12 P13 P14 P15 P2 P3 P4 P5 P6 P7 P9 VDD VSS
Xchip P1 P10 P11 P12 P13 P14 P15 P2 P3 P4 P5 P6 P7 P9 VDD VSS OSS_FRAME

* 1.0 pF load capacitance on all 14 signal pads
CP1  P1  0 1.0p
CP2  P2  0 1.0p
CP3  P3  0 1.0p
CP4  P4  0 1.0p
CP5  P5  0 1.0p
CP6  P6  0 1.0p
CP7  P7  0 1.0p
CP9  P9  0 1.0p
CP10 P10 0 1.0p
CP11 P11 0 1.0p
CP12 P12 0 1.0p
CP13 P13 0 1.0p
CP14 P14 0 1.0p
CP15 P15 0 1.0p

* Input stimulus on P1 (clk), P7 (rst), P10 (test)
VP1  P1  0 PWL(0.000n 0.0 998.000n 0.0 1000.000n 5.0 1498.000n 5.0 1500.000n 0.0 1998.000n 0.0 2000.000n 5.0 2498.000n 5.0 2500.000n 0.0 2998.000n 0.0 3000.000n 5.0 3498.000n 5.0 3500.000n 0.0 3998.000n 0.0 4000.000n 5.0 4498.000n 5.0 4500.000n 0.0 4998.000n 0.0 5000.000n 5.0 5498.000n 5.0 5500.000n 0.0 5998.000n 0.0 6000.000n 5.0 6498.000n 5.0 6500.000n 0.0 6998.000n 0.0 7000.000n 5.0 7498.000n 5.0 7500.000n 0.0 7998.000n 0.0 8000.000n 5.0 8498.000n 5.0 8500.000n 0.0 8998.000n 0.0 9000.000n 5.0 9498.000n 5.0 9500.000n 0.0 9998.000n 0.0 10000.000n 5.0 10498.000n 5.0 10500.000n 0.0 10998.000n 0.0 11000.000n 5.0 11498.000n 5.0 11500.000n 0.0 11998.000n 0.0 12000.000n 5.0 12498.000n 5.0 12500.000n 0.0 12998.000n 0.0 13000.000n 5.0 13498.000n 5.0 13500.000n 0.0 13998.000n 0.0 14000.000n 5.0 14498.000n 5.0 14500.000n 0.0 14998.000n 0.0 15000.000n 5.0 15498.000n 5.0 15500.000n 0.0 15998.000n 0.0 16000.000n 5.0 16498.000n 5.0 16500.000n 0.0 16998.000n 0.0 17000.000n 5.0 17498.000n 5.0 17500.000n 0.0 17998.000n 0.0 18000.000n 5.0 18498.000n 5.0 18500.000n 0.0 18998.000n 0.0 19000.000n 5.0 19498.000n 5.0 19500.000n 0.0 19998.000n 0.0 20000.000n 5.0 20498.000n 5.0 20500.000n 0.0 20998.000n 0.0 21000.000n 5.0 21498.000n 5.0 21500.000n 0.0 21998.000n 0.0 22000.000n 5.0 22498.000n 5.0 22500.000n 0.0 22998.000n 0.0 23000.000n 5.0 23498.000n 5.0 23500.000n 0.0 23998.000n 0.0 24000.000n 5.0 24498.000n 5.0 24500.000n 0.0 24998.000n 0.0 25000.000n 5.0 25498.000n 5.0 25500.000n 0.0 25998.000n 0.0 26000.000n 5.0 26498.000n 5.0 26500.000n 0.0 26998.000n 0.0 27000.000n 5.0 27498.000n 5.0 27500.000n 0.0 27998.000n 0.0 28000.000n 5.0 28498.000n 5.0 28500.000n 0.0 28998.000n 0.0 29000.000n 5.0 29498.000n 5.0 29500.000n 0.0 29998.000n 0.0 30000.000n 5.0 30498.000n 5.0 30500.000n 0.0 30998.000n 0.0 31000.000n 5.0 31498.000n 5.0 31500.000n 0.0 31998.000n 0.0 32000.000n 5.0 32498.000n 5.0 32500.000n 0.0 32998.000n 0.0 33000.000n 5.0 33498.000n 5.0 33500.000n 0.0 33998.000n 0.0 34000.000n 5.0 34498.000n 5.0 34500.000n 0.0 34998.000n 0.0 35000.000n 5.0 35498.000n 5.0 35500.000n 0.0 35998.000n 0.0 36000.000n 5.0 36498.000n 5.0 36500.000n 0.0 36998.000n 0.0 37000.000n 5.0 37498.000n 5.0 37500.000n 0.0 37998.000n 0.0 38000.000n 5.0 38498.000n 5.0 38500.000n 0.0 38998.000n 0.0 39000.000n 5.0 39498.000n 5.0 39500.000n 0.0 39998.000n 0.0 40000.000n 5.0 40498.000n 5.0 40500.000n 0.0 40998.000n 0.0 41000.000n 5.0 41498.000n 5.0 41500.000n 0.0 41998.000n 0.0 42000.000n 5.0 42498.000n 5.0 42500.000n 0.0 42998.000n 0.0 43000.000n 5.0 43498.000n 5.0 43500.000n 0.0 43998.000n 0.0 44000.000n 5.0 44498.000n 5.0 44500.000n 0.0 44998.000n 0.0 45000.000n 5.0 45498.000n 5.0 45500.000n 0.0 45998.000n 0.0 46000.000n 5.0 46498.000n 5.0 46500.000n 0.0 46998.000n 0.0 47000.000n 5.0 47498.000n 5.0 47500.000n 0.0 47998.000n 0.0 48000.000n 5.0 48498.000n 5.0 48500.000n 0.0 48998.000n 0.0 49000.000n 5.0 49498.000n 5.0 49500.000n 0.0 49998.000n 0.0 50000.000n 5.0 50498.000n 5.0 50500.000n 0.0 50998.000n 0.0 51000.000n 5.0 51498.000n 5.0 51500.000n 0.0 51998.000n 0.0 52000.000n 5.0 52498.000n 5.0 52500.000n 0.0 52998.000n 0.0 53000.000n 5.0 53498.000n 5.0 53500.000n 0.0 53998.000n 0.0 54000.000n 5.0 54498.000n 5.0 54500.000n 0.0 54998.000n 0.0 55000.000n 5.0 55498.000n 5.0 55500.000n 0.0 55998.000n 0.0 56000.000n 5.0 56498.000n 5.0 56500.000n 0.0 56998.000n 0.0 57000.000n 5.0 57498.000n 5.0 57500.000n 0.0 57998.000n 0.0 58000.000n 5.0 58498.000n 5.0 58500.000n 0.0 58998.000n 0.0 59000.000n 5.0 59498.000n 5.0 59500.000n 0.0 59998.000n 0.0 60000.000n 5.0 60498.000n 5.0 60500.000n 0.0 60998.000n 0.0 61000.000n 5.0 61498.000n 5.0 61500.000n 0.0 61998.000n 0.0 62000.000n 5.0 62498.000n 5.0 62500.000n 0.0 62998.000n 0.0 63000.000n 5.0 63498.000n 5.0 63500.000n 0.0 63998.000n 0.0 64000.000n 5.0 64498.000n 5.0 64500.000n 0.0 64998.000n 0.0 65000.000n 5.0 65498.000n 5.0 65500.000n 0.0 65998.000n 0.0 66000.000n 5.0 66498.000n 5.0 66500.000n 0.0 66998.000n 0.0 67000.000n 5.0 67498.000n 5.0 67500.000n 0.0 67998.000n 0.0 68000.000n 5.0 68498.000n 5.0 68500.000n 0.0 68998.000n 0.0 69000.000n 5.0 69498.000n 5.0 69500.000n 0.0 69998.000n 0.0 70000.000n 5.0 70498.000n 5.0 70500.000n 0.0 70998.000n 0.0 71000.000n 5.0 71498.000n 5.0 71500.000n 0.0 71998.000n 0.0 72000.000n 5.0 72498.000n 5.0 72500.000n 0.0 72998.000n 0.0 73000.000n 5.0 73498.000n 5.0 73500.000n 0.0 73998.000n 0.0 74000.000n 5.0 74498.000n 5.0 74500.000n 0.0 74998.000n 0.0 75000.000n 5.0 75498.000n 5.0 75500.000n 0.0 75998.000n 0.0 76000.000n 5.0 76498.000n 5.0 76500.000n 0.0 76998.000n 0.0 77000.000n 5.0 77498.000n 5.0 77500.000n 0.0 77998.000n 0.0 78000.000n 5.0 78498.000n 5.0 78500.000n 0.0 78998.000n 0.0 79000.000n 5.0 79498.000n 5.0 79500.000n 0.0 79998.000n 0.0 80000.000n 5.0 80498.000n 5.0 80500.000n 0.0 80998.000n 0.0 81000.000n 5.0 81498.000n 5.0 81500.000n 0.0 81998.000n 0.0 82000.000n 5.0 82498.000n 5.0 82500.000n 0.0 82998.000n 0.0 83000.000n 5.0 83498.000n 5.0 83500.000n 0.0 83998.000n 0.0 84000.000n 5.0 84498.000n 5.0 84500.000n 0.0 84998.000n 0.0 85000.000n 5.0 85498.000n 5.0 85500.000n 0.0 85998.000n 0.0 86000.000n 5.0 86498.000n 5.0 86500.000n 0.0 86998.000n 0.0 87000.000n 5.0 87498.000n 5.0 87500.000n 0.0 87998.000n 0.0 88000.000n 5.0 88498.000n 5.0 88500.000n 0.0 88998.000n 0.0 89000.000n 5.0 89498.000n 5.0 89500.000n 0.0 89998.000n 0.0 90000.000n 5.0 90498.000n 5.0 90500.000n 0.0 90998.000n 0.0)
VP7  P7  0 PWL(0 5.0 250.000n 5.0 252.000n 0.0)
VP10 P10 0 5.0

* Bidirectional Data Bus D[3:0] (P3=D3, P4=D2, P5=D1, P6=D0) tri-state ROM/RAM driver
Vdrv_en drv_en 0 PWL(0.000n 0.0 37016.000n 0.0 37018.000n 1.0 38998.000n 1.0 39000.000n 0.0 45016.000n 0.0 45018.000n 1.0 46998.000n 1.0 47000.000n 0.0 53016.000n 0.0 53018.000n 1.0 54998.000n 1.0 55000.000n 0.0 61016.000n 0.0 61018.000n 1.0 62998.000n 1.0 63000.000n 0.0 69016.000n 0.0 69018.000n 1.0 70998.000n 1.0 71000.000n 0.0 77016.000n 0.0 77018.000n 1.0 78998.000n 1.0 79000.000n 0.0 85016.000n 0.0 85018.000n 1.0 86998.000n 1.0 87000.000n 0.0)
Vrom_d0 rom_d0 0 PWL(0.000n 0.0 37014.000n 0.0 37016.000n 0.0 38003.000n 0.0 38005.000n 0.0 39002.000n 0.0 39004.000n 0.0 45014.000n 0.0 45016.000n 5.0 46003.000n 5.0 46005.000n 5.0 47002.000n 5.0 47004.000n 0.0 53014.000n 0.0 53016.000n 0.0 54003.000n 0.0 54005.000n 0.0 55002.000n 0.0 55004.000n 0.0 61014.000n 0.0 61016.000n 0.0 62003.000n 0.0 62005.000n 5.0 63002.000n 5.0 63004.000n 0.0 69014.000n 0.0 69016.000n 5.0 70003.000n 5.0 70005.000n 5.0 71002.000n 5.0 71004.000n 0.0 77014.000n 0.0 77016.000n 0.0 78003.000n 0.0 78005.000n 0.0 79002.000n 0.0 79004.000n 0.0 85014.000n 0.0 85016.000n 0.0 86003.000n 0.0 86005.000n 0.0 87002.000n 0.0 87004.000n 0.0)
Vrom_d1 rom_d1 0 PWL(0.000n 0.0 37014.000n 0.0 37016.000n 5.0 38003.000n 5.0 38005.000n 0.0 39002.000n 0.0 39004.000n 0.0 45014.000n 0.0 45016.000n 0.0 46003.000n 0.0 46005.000n 5.0 47002.000n 5.0 47004.000n 0.0 53014.000n 0.0 53016.000n 5.0 54003.000n 5.0 54005.000n 0.0 55002.000n 0.0 55004.000n 0.0 61014.000n 0.0 61016.000n 0.0 62003.000n 0.0 62005.000n 0.0 63002.000n 0.0 63004.000n 0.0 69014.000n 0.0 69016.000n 5.0 70003.000n 5.0 70005.000n 0.0 71002.000n 0.0 71004.000n 0.0 77014.000n 0.0 77016.000n 0.0 78003.000n 0.0 78005.000n 0.0 79002.000n 0.0 79004.000n 0.0 85014.000n 0.0 85016.000n 5.0 86003.000n 5.0 86005.000n 5.0 87002.000n 5.0 87004.000n 0.0)
Vrom_d2 rom_d2 0 PWL(0.000n 0.0 37014.000n 0.0 37016.000n 0.0 38003.000n 0.0 38005.000n 0.0 39002.000n 0.0 39004.000n 0.0 45014.000n 0.0 45016.000n 0.0 46003.000n 0.0 46005.000n 5.0 47002.000n 5.0 47004.000n 0.0 53014.000n 0.0 53016.000n 0.0 54003.000n 0.0 54005.000n 0.0 55002.000n 0.0 55004.000n 0.0 61014.000n 0.0 61016.000n 0.0 62003.000n 0.0 62005.000n 0.0 63002.000n 0.0 63004.000n 0.0 69014.000n 0.0 69016.000n 5.0 70003.000n 5.0 70005.000n 5.0 71002.000n 5.0 71004.000n 0.0 77014.000n 0.0 77016.000n 0.0 78003.000n 0.0 78005.000n 0.0 79002.000n 0.0 79004.000n 0.0 85014.000n 0.0 85016.000n 5.0 86003.000n 5.0 86005.000n 0.0 87002.000n 0.0 87004.000n 0.0)
Vrom_d3 rom_d3 0 PWL(0.000n 0.0 37014.000n 0.0 37016.000n 0.0 38003.000n 0.0 38005.000n 0.0 39002.000n 0.0 39004.000n 0.0 45014.000n 0.0 45016.000n 5.0 46003.000n 5.0 46005.000n 0.0 47002.000n 0.0 47004.000n 0.0 53014.000n 0.0 53016.000n 5.0 54003.000n 5.0 54005.000n 0.0 55002.000n 0.0 55004.000n 0.0 61014.000n 0.0 61016.000n 5.0 62003.000n 5.0 62005.000n 0.0 63002.000n 0.0 63004.000n 0.0 69014.000n 0.0 69016.000n 5.0 70003.000n 5.0 70005.000n 0.0 71002.000n 0.0 71004.000n 0.0 77014.000n 0.0 77016.000n 5.0 78003.000n 5.0 78005.000n 0.0 79002.000n 0.0 79004.000n 0.0 85014.000n 0.0 85016.000n 5.0 86003.000n 5.0 86005.000n 0.0 87002.000n 0.0 87004.000n 0.0)
Bd0 P6 0 I = V(drv_en) * (V(P6) - V(rom_d0)) / 100.0
Bd1 P5 0 I = V(drv_en) * (V(P5) - V(rom_d1)) / 100.0
Bd2 P4 0 I = V(drv_en) * (V(P4) - V(rom_d2)) / 100.0
Bd3 P3 0 I = V(drv_en) * (V(P3) - V(rom_d3)) / 100.0

.tran 12.500n 90200.000n 0 25.000n
.meas tran pc6_l_d0 FIND v(P6) AT=82900.000n
.meas tran pc6_l_d1 FIND v(P5) AT=82900.000n
.meas tran pc6_l_d2 FIND v(P4) AT=82900.000n
.meas tran pc6_l_d3 FIND v(P3) AT=82900.000n
.meas tran pc6_l_doe FIND v(P9) AT=82900.000n
.meas tran pc6_m_d0 FIND v(P6) AT=83900.000n
.meas tran pc6_m_d1 FIND v(P5) AT=83900.000n
.meas tran pc6_m_d2 FIND v(P4) AT=83900.000n
.meas tran pc6_m_d3 FIND v(P3) AT=83900.000n
.meas tran pc6_m_doe FIND v(P9) AT=83900.000n
.meas tran pc6_h_d0 FIND v(P6) AT=84900.000n
.meas tran pc6_h_d1 FIND v(P5) AT=84900.000n
.meas tran pc6_h_d2 FIND v(P4) AT=84900.000n
.meas tran pc6_h_d3 FIND v(P3) AT=84900.000n
.meas tran pc6_h_doe FIND v(P9) AT=84900.000n
.meas tran final_acc_d0 FIND v(P6) AT=88900.000n
.meas tran final_acc_d1 FIND v(P5) AT=88900.000n
.meas tran final_acc_d2 FIND v(P4) AT=88900.000n
.meas tran final_acc_d3 FIND v(P3) AT=88900.000n
.meas tran final_acc_doe FIND v(P9) AT=88900.000n
.meas tran tpd_sync TRIG v(P1) VAL=2.5 RISE=1 TD=40800.000n TARG v(P2) VAL=2.5 RISE=1 TD=40800.000n
.meas tran tpd_cmrom TRIG v(P1) VAL=2.5 RISE=1 TD=35800.000n TARG v(P15) VAL=2.5 RISE=1 TD=35800.000n
.meas tran tpd_cmram0 TRIG v(P1) VAL=2.5 RISE=1 TD=35800.000n TARG v(P11) VAL=2.5 RISE=1 TD=35800.000n
.meas tran tpd_doe TRIG v(P1) VAL=2.5 RISE=1 TD=36800.000n TARG v(P9) VAL=2.5 FALL=1 TD=36800.000n
.meas tran tpd_dout0 TRIG v(P1) VAL=2.5 RISE=1 TD=41800.000n TARG v(P6) VAL=2.5 RISE=1 TD=41800.000n
.meas tran i_vdd_avg AVG i(VVDD) FROM=34000.000n TO=90000.000n
.end
