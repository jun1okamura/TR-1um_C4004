* TB3: JMS/BBL Stack in SRAM128 & JCN with TEST Pad
* Full-Chip Extracted Netlist Verification (OSS_FRAME.extracted)
* Clock Period T_clk = 100.000 ns (f_clk = 10.00 MHz)

.include "models.spice"
.include "OSS_FRAME_extracted_sim.spice"

.option reltol=1e-3 abstol=1e-9 vntol=1e-4 method=trap

* Power Supplies (5.0V)
VVDD VDD 0 5.0
VVSS VSS 0 0.0

* Clock P1: Held Low (0V) during Reset [0, 1.5*T]; first rising edge at t = 1.5*T
VCLK P1 0 PULSE(0 5.0 150.000n 0.500n 0.500n 49.500n 100.000n)

* Reset P7: Active High (5V) for [0, 1.0*T] while CLK=0, deasserted at 1.0*T
* Machine Cycle 0 State A1 begins at rising edge #1 (t = 1.5 * T_clk)
VRST P7 0 PWL(0n 5.0 99.500n 5.0 100.000n 0.0)

* TEST Input Pad P10
VTEST P10 0 PWL(0.000n 0.00 150.000n 0.00 950.000n 0.00 1750.000n 0.00 2550.000n 0.00 3349.500n 0.00 3350.000n 5.00 4150.000n 5.00 4949.500n 5.00 4950.000n 0.00)

* Tri-State External ROM/RAM Bus Driver for Bidirectional Pads P3(D3)..P6(D0)
V_TB_EN TB_EN 0 PWL(0.000n 0.00 459.500n 0.00 460.000n 5.00 659.500n 5.00 660.000n 0.00 1259.500n 0.00 1260.000n 5.00 1459.500n 5.00 1460.000n 0.00 2059.500n 0.00 2060.000n 5.00 2259.500n 5.00 2260.000n 0.00 2859.500n 0.00 2860.000n 5.00 3059.500n 5.00 3060.000n 0.00 3659.500n 0.00 3660.000n 5.00 3859.500n 5.00 3860.000n 0.00 4459.500n 0.00 4460.000n 5.00 4659.500n 5.00 4660.000n 0.00 5259.500n 0.00 5260.000n 5.00 5459.500n 5.00 5460.000n 0.00)
V_D3 D3_SRC 0 PWL(0.000n 0.00 459.500n 0.00 560.000n 0.00 1259.500n 0.00 1360.000n 0.00 2059.000n 0.00 2059.500n 5.00 2160.000n 5.00 2859.500n 5.00 2959.500n 5.00 2960.000n 0.00 3659.500n 0.00 3760.000n 0.00 4459.500n 0.00 4560.000n 0.00 5259.500n 0.00 5360.000n 0.00)
V_D2 D2_SRC 0 PWL(0.000n 0.00 459.000n 0.00 459.500n 5.00 559.500n 5.00 560.000n 0.00 1259.500n 0.00 1360.000n 0.00 2059.000n 0.00 2059.500n 5.00 2160.000n 5.00 2859.500n 5.00 2959.500n 5.00 2960.000n 0.00 3659.500n 0.00 3760.000n 0.00 4459.000n 0.00 4459.500n 5.00 4560.000n 5.00 5259.000n 5.00 5259.500n 0.00 5360.000n 0.00)
V_D1 D1_SRC 0 PWL(0.000n 0.00 459.500n 0.00 560.000n 0.00 1259.000n 0.00 1259.500n 5.00 1360.000n 5.00 2059.000n 5.00 2059.500n 0.00 2160.000n 0.00 2859.000n 0.00 2859.500n 5.00 2959.500n 5.00 2960.000n 0.00 3659.500n 0.00 3760.000n 0.00 4459.500n 0.00 4560.000n 0.00 5259.500n 0.00 5360.000n 0.00)
V_D0 D0_SRC 0 PWL(0.000n 0.00 459.000n 0.00 459.500n 5.00 560.000n 5.00 1259.000n 5.00 1259.500n 0.00 1359.500n 0.00 1360.000n 5.00 2059.000n 5.00 2059.500n 0.00 2160.000n 0.00 2859.500n 0.00 2960.000n 0.00 3659.000n 0.00 3659.500n 5.00 3760.000n 5.00 4459.000n 5.00 4459.500n 0.00 4559.500n 0.00 4560.000n 5.00 5259.000n 5.00 5259.500n 0.00 5360.000n 0.00)

.model SW_ROM SW(vt=2.5 vh=0.2 ron=5 roff=10Meg)
S_D3 P3 D3_SRC TB_EN 0 SW_ROM
S_D2 P4 D2_SRC TB_EN 0 SW_ROM
S_D1 P5 D1_SRC TB_EN 0 SW_ROM
S_D0 P6 D0_SRC TB_EN 0 SW_ROM

* Capacitive Probe Loads on All Output & Bidirectional Bondpads (1.0 pF)
C_P2  P2  0 1.0p
C_P3  P3  0 1.0p
C_P4  P4  0 1.0p
C_P5  P5  0 1.0p
C_P6  P6  0 1.0p
C_P9  P9  0 1.0p
C_P11 P11 0 1.0p
C_P12 P12 0 1.0p
C_P13 P13 0 1.0p
C_P14 P14 0 1.0p
C_P15 P15 0 1.0p

* Device Under Test: Full Chip OSS_FRAME (16 Pads)
* Port order: P1 P10 P11 P12 P13 P14 P15 P2 P3 P4 P5 P6 P7 P9 VDD VSS
XUUT P1 P10 P11 P12 P13 P14 P15 P2 P3 P4 P5 P6 P7 P9 VDD VSS OSS_FRAME

.meas tran c2_a1_d3 FIND v(P3) AT=1835.000n
.meas tran c2_a1_d2 FIND v(P4) AT=1835.000n
.meas tran c2_a1_d1 FIND v(P5) AT=1835.000n
.meas tran c2_a1_d0 FIND v(P6) AT=1835.000n
.meas tran c2_a1_doe FIND v(P9) AT=1835.000n
.meas tran c2_a1_sync FIND v(P2) AT=1835.000n
.meas tran c2_a1_cmrom FIND v(P15) AT=1835.000n
.meas tran c2_a2_d3 FIND v(P3) AT=1935.000n
.meas tran c2_a2_d2 FIND v(P4) AT=1935.000n
.meas tran c2_a2_d1 FIND v(P5) AT=1935.000n
.meas tran c2_a2_d0 FIND v(P6) AT=1935.000n
.meas tran c2_a2_doe FIND v(P9) AT=1935.000n
.meas tran c2_a2_sync FIND v(P2) AT=1935.000n
.meas tran c2_a2_cmrom FIND v(P15) AT=1935.000n
.meas tran c2_a3_d3 FIND v(P3) AT=2035.000n
.meas tran c2_a3_d2 FIND v(P4) AT=2035.000n
.meas tran c2_a3_d1 FIND v(P5) AT=2035.000n
.meas tran c2_a3_d0 FIND v(P6) AT=2035.000n
.meas tran c2_a3_doe FIND v(P9) AT=2035.000n
.meas tran c2_a3_sync FIND v(P2) AT=2035.000n
.meas tran c2_a3_cmrom FIND v(P15) AT=2035.000n
.meas tran c3_a1_d3 FIND v(P3) AT=2635.000n
.meas tran c3_a1_d2 FIND v(P4) AT=2635.000n
.meas tran c3_a1_d1 FIND v(P5) AT=2635.000n
.meas tran c3_a1_d0 FIND v(P6) AT=2635.000n
.meas tran c3_a1_doe FIND v(P9) AT=2635.000n
.meas tran c3_a1_sync FIND v(P2) AT=2635.000n
.meas tran c3_a1_cmrom FIND v(P15) AT=2635.000n
.meas tran c3_a2_d3 FIND v(P3) AT=2735.000n
.meas tran c3_a2_d2 FIND v(P4) AT=2735.000n
.meas tran c3_a2_d1 FIND v(P5) AT=2735.000n
.meas tran c3_a2_d0 FIND v(P6) AT=2735.000n
.meas tran c3_a2_doe FIND v(P9) AT=2735.000n
.meas tran c3_a2_sync FIND v(P2) AT=2735.000n
.meas tran c3_a2_cmrom FIND v(P15) AT=2735.000n
.meas tran c3_a3_d3 FIND v(P3) AT=2835.000n
.meas tran c3_a3_d2 FIND v(P4) AT=2835.000n
.meas tran c3_a3_d1 FIND v(P5) AT=2835.000n
.meas tran c3_a3_d0 FIND v(P6) AT=2835.000n
.meas tran c3_a3_doe FIND v(P9) AT=2835.000n
.meas tran c3_a3_sync FIND v(P2) AT=2835.000n
.meas tran c3_a3_cmrom FIND v(P15) AT=2835.000n
.meas tran c3_wrm_d3 FIND v(P3) AT=3235.000n
.meas tran c3_wrm_d2 FIND v(P4) AT=3235.000n
.meas tran c3_wrm_d1 FIND v(P5) AT=3235.000n
.meas tran c3_wrm_d0 FIND v(P6) AT=3235.000n
.meas tran c3_wrm_doe FIND v(P9) AT=3235.000n
.meas tran c3_wrm_sync FIND v(P2) AT=3235.000n
.meas tran c3_wrm_cmrom FIND v(P15) AT=3235.000n
.meas tran c6_a1_d3 FIND v(P3) AT=5035.000n
.meas tran c6_a1_d2 FIND v(P4) AT=5035.000n
.meas tran c6_a1_d1 FIND v(P5) AT=5035.000n
.meas tran c6_a1_d0 FIND v(P6) AT=5035.000n
.meas tran c6_a1_doe FIND v(P9) AT=5035.000n
.meas tran c6_a1_sync FIND v(P2) AT=5035.000n
.meas tran c6_a1_cmrom FIND v(P15) AT=5035.000n
.meas tran c6_a2_d3 FIND v(P3) AT=5135.000n
.meas tran c6_a2_d2 FIND v(P4) AT=5135.000n
.meas tran c6_a2_d1 FIND v(P5) AT=5135.000n
.meas tran c6_a2_d0 FIND v(P6) AT=5135.000n
.meas tran c6_a2_doe FIND v(P9) AT=5135.000n
.meas tran c6_a2_sync FIND v(P2) AT=5135.000n
.meas tran c6_a2_cmrom FIND v(P15) AT=5135.000n
.meas tran c6_a3_d3 FIND v(P3) AT=5235.000n
.meas tran c6_a3_d2 FIND v(P4) AT=5235.000n
.meas tran c6_a3_d1 FIND v(P5) AT=5235.000n
.meas tran c6_a3_d0 FIND v(P6) AT=5235.000n
.meas tran c6_a3_doe FIND v(P9) AT=5235.000n
.meas tran c6_a3_sync FIND v(P2) AT=5235.000n
.meas tran c6_a3_cmrom FIND v(P15) AT=5235.000n
.meas tran idd_avg AVG i(VVDD) FROM=150.000n TO=5800.000n

.tran 2.000n 5800.000n
.end
