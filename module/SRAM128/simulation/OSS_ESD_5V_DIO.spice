** sch_path: /Users/okamura/Dropbox/91_OpenPDK/TR-1um/libs.tech/xschem/TR-1um_frame/OSS_ESD_5V_DIO.sch
.subckt OSS_ESD_5V_DIO VDD PAD VSS HIZ OUT
*.PININFO PAD:B VDD:B VSS:B HIZ:I OUT:I
MXM1 PAD PG VDD VDD PMOS w=300u l=2u
MXM2 PAD NG VSS VSS NMOSE w=150u l=2u
MXM3 PG PGG VDD VDD PMOS w=20.8u l=1u
MXM4 PG PGG VSS VSS NMOS w=6.8u l=1u
MXM5 PAD VDD VDD VDD PMOS w=200u l=2u
MXM6 PAD VSS VSS VSS NMOSE w=350u l=2u
MXM7 NG NGG VDD VDD PMOS w=20.8u l=1u
MXM8 NG NGG VSS VSS NMOS w=6.8u l=1u
MXM9 PGG HIZ net2 VDD PMOS w=10.4u l=1u
MXM10 net2 net1 VDD VDD PMOS w=10.4u l=1u
MXM11 PGG net1 VSS VSS NMOS w=3.4u l=1u
MXM12 PGG HIZ VSS VSS NMOS w=3.4u l=1u
MXM13 NGG net1 VDD VDD PMOS w=5.2u l=1u
MXM14 NGG ENB VDD VDD PMOS w=5.2u l=1u
MXM15 NGG ENB net3 VSS NMOS w=3.4u l=1u
MXM16 net3 net1 VSS VSS NMOS w=3.4u l=1u
MXM17 ENB HIZ VDD VDD PMOS w=5.2u l=1u
MXM18 ENB HIZ VSS VSS NMOS w=3.4u l=1u
DD1 VSS HIZ DN A=12.96p P=14.4u
MXM19 net1 OUT VDD VDD PMOS w=5.2u l=1u
MXM20 net1 OUT VSS VSS NMOS w=3.4u l=1u
DD2 VSS OUT DN A=12.96p P=14.4u
.ends
