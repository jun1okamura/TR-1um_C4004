** sch_path: /Users/okamura/Dropbox/91_OpenPDK/TR-1um/libs.tech/xschem/IP62_5_stdcell/BUF_X1.sch
.subckt BUF_X1 VDD A Y GND
*.PININFO A:I Y:O VDD:B GND:B
MM7 net1 A VDD VDD PMOS w=10.2u l=1u
MM1 Y net1 VDD VDD PMOS w=10.2u l=1u
MM3 net1 A GND GND NMOS w=3.4u l=1u
MM2 Y net1 GND GND NMOS w=3.4u l=1u
.ends
