** sch_path: /Users/okamura/Dropbox/91_OpenPDK/TR-1um/libs.tech/xschem/IP62_5_stdcell/DEL1.sch
.subckt DEL1 VDD A Y GND
*.PININFO A:I Y:O VDD:B GND:B
MM9 net3 A VDD VDD PMOS w=10.2u l=1u
MM2 Y net1 VDD VDD PMOS w=10.2u l=1u m=2
MM8 net3 A GND GND NMOS w=3.4u l=1u
MM1 Y net1 GND GND NMOS w=3.4u l=1u m=2
MM4 net2 net3 VDD VDD PMOS w=10.2u l=2u
MM6 net1 net2 VDD VDD PMOS w=10.2u l=2u
MM7 net2 net3 GND GND NMOS w=3.4u l=2u
MM3 net1 net2 GND GND NMOS w=3.4u l=2u
.ends
