** sch_path: /Users/okamura/Dropbox/91_OpenPDK/TR-1um/libs.tech/xschem/IP62_5_stdcell/OR4.sch
.subckt OR4 A B C D VDD Y GND
*.PININFO B:I A:I Y:O VDD:B GND:B C:I D:I
MM10 net1 B VDD VDD PMOS w=10.2u l=1u
MM2 net2 A net1 VDD PMOS w=10.2u l=1u
MM3 net4 C net2 VDD PMOS w=10.2u l=1u
MM7 Y net3 VDD VDD PMOS w=10.2u l=1u
MM9 net4 D net3 VDD PMOS w=10.2u l=1u
MM11 net3 A GND GND NMOS w=3.4u l=1u
MM1 net3 B GND GND NMOS w=3.4u l=1u
MM4 net3 C GND GND NMOS w=3.4u l=1u
MM5 net3 D GND GND NMOS w=3.4u l=1u
MM6 Y net3 GND GND NMOS w=3.4u l=1u
.ends
