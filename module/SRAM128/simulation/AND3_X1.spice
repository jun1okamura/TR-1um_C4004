** sch_path: /Users/okamura/Dropbox/91_OpenPDK/TR-1um/libs.tech/xschem/IP62_5_stdcell/AND3_X1.sch
.subckt AND3_X1 C VDD Y A B GND
*.PININFO Y:O A:I B:I VDD:B GND:B C:I
MM4 net1 C VDD VDD PMOS w=10.2u l=1u
MM2 net1 B VDD VDD PMOS w=10.2u l=1u
MM3 Y net1 VDD VDD PMOS w=10.2u l=1u
MM1 VDD A net1 VDD PMOS w=10.2u l=1u
MM8 Y net1 GND GND NMOS w=3.4u l=1u
MM5 net1 A net3 GND NMOS w=3.4u l=1u
MM6 net3 B net2 GND NMOS w=3.4u l=1u
MM7 net2 C GND GND NMOS w=3.4u l=1u
.ends
