** sch_path: /Users/okamura/Dropbox/91_OpenPDK/TR-1um/libs.tech/xschem/TR-1um_frame/OSS_FRAME_IO.sch
.subckt OSS_FRAME_IO P1 P2 P3 P4 P5 P6 P7 VSS VDD P15 P14 P13 P12 P11 P10 P9 ENB1 OUT1 ENB2 OUT2 ENB3 OUT3 ENB4 OUT4 ENB5 OUT5
+ ENB6 OUT6 ENB7 OUT7 ENB15 OUT15 ENB14 OUT14 ENB13 OUT13 ENB12 OUT12 ENB11 OUT11 ENB10 OUT10 ENB9 OUT9
*.PININFO P1:B P2:B P3:B P4:B P5:B P6:B P7:B VSS:B VDD:B P15:B P14:B P13:B P12:B P11:B P10:B P9:B ENB1:I OUT1:I ENB2:I OUT2:I
*+ ENB3:I OUT3:I ENB4:I OUT4:I ENB5:I OUT5:I ENB6:I OUT6:I ENB7:I OUT7:I ENB15:I OUT15:I ENB14:I OUT14:I ENB13:I OUT13:I ENB12:I OUT12:I
*+ ENB11:I OUT11:I ENB10:I OUT10:I ENB9:I OUT9:I
x1 VDD P1 VSS ENB1 OUT1 OSS_ESD_5V_DIO
x2 VDD VSS OSS_ESD_5V_VDD
x3 VDD VSS OSS_ESD_5V_VSS
x4 VDD P2 VSS ENB2 OUT2 OSS_ESD_5V_DIO
x5 VDD P3 VSS ENB3 OUT3 OSS_ESD_5V_DIO
x6 VDD P4 VSS ENB4 OUT4 OSS_ESD_5V_DIO
x7 VDD P5 VSS ENB5 OUT5 OSS_ESD_5V_DIO
x8 VDD P6 VSS ENB6 OUT6 OSS_ESD_5V_DIO
x9 VDD P7 VSS ENB7 OUT7 OSS_ESD_5V_DIO
x10 VDD P15 VSS ENB15 OUT15 OSS_ESD_5V_DIO
x11 VDD P14 VSS ENB14 OUT14 OSS_ESD_5V_DIO
x12 VDD P13 VSS ENB13 OUT13 OSS_ESD_5V_DIO
x13 VDD P12 VSS ENB12 OUT12 OSS_ESD_5V_DIO
x14 VDD P11 VSS ENB11 OUT11 OSS_ESD_5V_DIO
x15 VDD P10 VSS ENB10 OUT10 OSS_ESD_5V_DIO
x16 VDD P9 VSS ENB9 OUT9 OSS_ESD_5V_DIO
.ends

* expanding   symbol:  OSS_ESD_5V_DIO.sym # of pins=6
** sym_path: /Users/okamura/Dropbox/91_OpenPDK/TR-1um/libs.tech/xschem/TR-1um_frame/OSS_ESD_5V_DIO.sym
** sch_path: /Users/okamura/Dropbox/91_OpenPDK/TR-1um/libs.tech/xschem/TR-1um_frame/OSS_ESD_5V_DIO.sch
.subckt OSS_ESD_5V_DIO VDD PAD VSS ENB OUT
*.PININFO PAD:B VDD:B VSS:B ENB:I OUT:I
MXM1 PAD PG VDD VDD PMOS w=300u l=2u
MXM2 PAD NG VSS VSS NMOSE w=200u l=2u
MXM3 PG PGG VDD VDD PMOS w=20.8u l=1u
MXM4 PG PGG VSS VSS NMOS w=6.8u l=1u
MXM5 PAD VDD VDD VDD PMOS w=200u l=2u
MXM6 PAD VSS VSS VSS NMOSE w=300u l=2u
MXM7 NG NGG VDD VDD PMOS w=20.8u l=1u
MXM8 NG NGG VSS VSS NMOS w=6.8u l=1u
MXM9 PGG ENB_ net1 VDD PMOS w=10.4u l=1u
MXM10 net1 OUT VDD VDD PMOS w=10.4u l=1u
MXM11 PGG OUT VSS VSS NMOS w=3.4u l=1u
MXM12 PGG ENB_ VSS VSS NMOS w=3.4u l=1u
MXM13 NGG OUT VDD VDD PMOS w=5.2u l=1u
MXM14 NGG ENB VDD VDD PMOS w=5.2u l=1u
MXM15 NGG ENB net2 VSS NMOS w=3.4u l=1u
MXM16 net2 OUT VSS VSS NMOS w=3.4u l=1u
MXM17 ENB_ ENB VDD VDD PMOS w=5.2u l=1u
MXM18 ENB_ ENB VSS VSS NMOS w=3.4u l=1u
DD1 VSS ENB DN A=12.96p P=14.4u
DD2 OUT VDD DP A=12.96p P=14.4u
.ends

* expanding   symbol:  OSS_ESD_5V_VDD.sym # of pins=3
** sym_path: /Users/okamura/Dropbox/91_OpenPDK/TR-1um/libs.tech/xschem/TR-1um_frame/OSS_ESD_5V_VDD.sym
** sch_path: /Users/okamura/Dropbox/91_OpenPDK/TR-1um/libs.tech/xschem/TR-1um_frame/OSS_ESD_5V_VDD.sch
.subckt OSS_ESD_5V_VDD VDD VSS
*.PININFO VSS:B VDD:B VDD:B
MXM5 VSS VDD VDD VDD PMOS w=500u l=2u
MXM6 VDD VSS VSS VSS NMOSE w=500u l=2u
.ends

* expanding   symbol:  OSS_ESD_5V_VSS.sym # of pins=3
** sym_path: /Users/okamura/Dropbox/91_OpenPDK/TR-1um/libs.tech/xschem/TR-1um_frame/OSS_ESD_5V_VSS.sym
** sch_path: /Users/okamura/Dropbox/91_OpenPDK/TR-1um/libs.tech/xschem/TR-1um_frame/OSS_ESD_5V_VSS.sch
.subckt OSS_ESD_5V_VSS VDD VSS
*.PININFO VSS:B VDD:B VSS:B
MXM3 VSS VDD VDD VDD PMOS w=500u l=2u
MXM4 VDD VSS VSS VSS NMOSE w=500u l=2u
.ends
