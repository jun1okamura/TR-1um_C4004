** sch_path: /Users/okamura/Dropbox/98_LSI_Design/TR-1um_Async_I2C/LEF/XNOR2.sch
.subckt XNOR2 VDD Y A B GND
*.PININFO VDD:B GND:B A:I B:I Y:O
MM10 net1 A VDD VDD PMOS w=10.2u l=1u
MM1 net1 B VDD VDD PMOS w=10.2u l=1u
MM2 Y net1 VDD VDD PMOS w=10.2u l=1u
MM3 net4 B VDD VDD PMOS w=10.2u l=1u
MM4 Y A net4 VDD PMOS w=10.2u l=1u
MM11 net1 B net3 GND NMOS w=3.4u l=1u
MM5 net3 A GND GND NMOS w=3.4u l=1u
MM6 Y net1 net2 GND NMOS w=3.4u l=1u
MM7 net2 A GND GND NMOS w=3.4u l=1u
MM8 net2 B GND GND NMOS w=3.4u l=1u
.ends
