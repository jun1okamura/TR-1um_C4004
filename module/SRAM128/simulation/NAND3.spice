** sch_path: /Users/okamura/Dropbox/91_OpenPDK/TR-1um/libs.tech/xschem/IP62_5_stdcell/NAND3.sch
.subckt NAND3 C VDD Y A B GND
*.PININFO B:I A:I Y:O GND:B VDD:B C:I
MM1 Y A VDD VDD PMOS w=10.2u l=1u
MM4 Y B VDD VDD PMOS w=10.2u l=1u
MM6 Y C VDD VDD PMOS w=10.2u l=1u
MM7 Y C net1 GND NMOS w=3.4u l=1u
MM2 net1 B net2 GND NMOS w=3.4u l=1u
MM3 net2 A GND GND NMOS w=3.4u l=1u
.ends
