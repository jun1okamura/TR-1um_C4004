** sch_path: /Users/okamura/Dropbox/98_LSI_Design/TR-1um_Async_I2C/LEF/FILL2.sch
.subckt FILL2 GND VDD
*.PININFO GND:B VDD:B
MM7 VDD GND VDD VDD PMOS w=21.2u l=3.2u
MM2 GND VDD GND GND NMOS w=13.1u l=3.2u
.ends
