** sch_path: /Users/okamura/Dropbox/98_LSI_Design/TR-1um_Async_I2C/LEF/XOR2.sch
.subckt XOR2 VDD Y A B GND
*.PININFO VDD:B GND:B A:I B:I Y:O
MM10 net1 A VDD VDD PMOS w=10.2u l=1u
MM1 net2 B net1 VDD PMOS w=10.2u l=1u
MM8 net3 A VDD VDD PMOS w=10.2u l=1u
MM2 net3 B VDD VDD PMOS w=10.2u l=1u
MM9 Y net2 net3 VDD PMOS w=10.2u l=1u
MM3 net2 A GND GND NMOS w=3.4u l=1u
MM4 net2 B GND GND NMOS w=3.4u l=1u
MM5 Y net2 GND GND NMOS w=3.4u l=1u
MM7 net4 B GND GND NMOS w=3.4u l=1u
MM6 Y A net4 GND NMOS w=3.4u l=1u
.ends
