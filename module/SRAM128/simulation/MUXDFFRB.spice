** sch_path: /Users/okamura/Dropbox/98_LSI_Design/TR-1um_Async_I2C/LEF/MUXDFFRB.sch
.subckt MUXDFFRB VDD A Q B CK S QB VSS RSTB
*.PININFO A:I B:I CK:I Q:O QB:O VDD:B VSS:B S:I RSTB:I
x1 VDD QB net1 Q RSTB VSS CK DFFRB
x2 A B S VDD net1 VSS MUX2
.ends

* expanding   symbol:  ./DFFRB.sym # of pins=7
** sym_path: /Users/okamura/Dropbox/98_LSI_Design/TR-1um_Async_I2C/LEF/DFFRB.sym
** sch_path: /Users/okamura/Dropbox/98_LSI_Design/TR-1um_Async_I2C/LEF/DFFRB.sch
.subckt DFFRB VDD QB D Q RSTB GND CK
*.PININFO VDD:B GND:B D:I QB:O CK:I Q:O RSTB:I
MM2 net1 D VDD VDD PMOS w=5.2u l=1u
MM1 net2 CKP net1 VDD PMOS w=5.2u l=1u
MM7 net2 CKB net3 GND NMOS w=3.4u l=1u
MM8 net3 D GND GND NMOS w=3.4u l=1u
MM10 QM net2 VDD VDD PMOS w=5.2u l=1u
MM11 QM net2 GND GND NMOS w=3.4u l=1u
MM13 net4 QM GND GND NMOS w=3.4u l=1u
MM15 net4 CKP net2 GND NMOS w=3.4u l=1u
MM22 QB QS VDD VDD PMOS w=10.4u l=1u
MM3 net4 QM VDD VDD PMOS w=5.2u l=1u
MM4 net2 CKB net4 VDD PMOS w=5.2u l=1u
MM5 QS CKP QM GND NMOS w=3.4u l=1u
MM6 QM CKB QS VDD PMOS w=5.2u l=1u
MM9 net5 QB GND GND NMOS w=3.4u l=1u
MM12 net5 QB VDD VDD PMOS w=5.2u l=1u
MM14 net5 CKB QS GND NMOS w=3.4u l=1u
MM16 QS CKP net5 VDD PMOS w=5.2u l=1u
MM17 QB RSTB net6 GND NMOS w=3.4u l=1u
MM18 Q QB VDD VDD PMOS w=10.4u l=1u
MM19 Q QB GND GND NMOS w=3.4u l=1u
MM20 CKB CK VDD VDD PMOS w=10.4u l=1u
MM21 CKB CK GND GND NMOS w=3.4u l=1u
MM23 CKP CKB VDD VDD PMOS w=10.4u l=1u
MM24 CKP CKB GND GND NMOS w=3.4u l=1u
MM25 net6 QS GND GND NMOS w=3.4u l=1u
MM26 QB RSTB VDD VDD PMOS w=10.4u l=1u
.ends

* expanding   symbol:  ./MUX2.sym # of pins=6
** sym_path: /Users/okamura/Dropbox/98_LSI_Design/TR-1um_Async_I2C/LEF/MUX2.sym
** sch_path: /Users/okamura/Dropbox/98_LSI_Design/TR-1um_Async_I2C/LEF/MUX2.sch
.subckt MUX2 A B S VDD Y GND
*.PININFO S:I Y:O VDD:B GND:B B:I A:I
MM13 SB S VDD VDD PMOS w=6.8u l=1u
MM8 net2 S net3 VDD PMOS w=6.8u l=1u
MM12 SB S GND GND NMOS w=3.4u l=1u
MM6 net2 SB net3 GND NMOS w=3.4u l=1u
MM11 net1 B VDD VDD PMOS w=6.8u l=1u
MM14 net1 B GND GND NMOS w=3.4u l=1u
MM15 net2 A VDD VDD PMOS w=6.8u l=1u
MM16 net2 A GND GND NMOS w=3.4u l=1u
MM3 net1 SB net3 VDD PMOS w=6.8u l=1u
MM5 net1 S net3 GND NMOS w=3.4u l=1u
MM1 Y net3 VDD VDD PMOS w=11.2u l=1u
MM2 Y net3 GND GND NMOS w=3.4u l=1u
.ends
