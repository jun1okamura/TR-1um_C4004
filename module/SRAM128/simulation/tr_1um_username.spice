** sch_path: /Users/okamura/Dropbox/91_OpenPDK/WorkDir/tr_1um_username.sch
**.subckt tr_1um_username P1 P2 P3 P4 P5 P6 P7 VSS VDD P15 P14 P13 P12 P11 P10 P9
*.iopin P1
*.iopin P2
*.iopin P3
*.iopin P4
*.iopin P5
*.iopin P6
*.iopin P7
*.iopin VSS
*.iopin VDD
*.iopin P15
*.iopin P14
*.iopin P13
*.iopin P12
*.iopin P11
*.iopin P10
*.iopin P9
x1 P1 VDD P2 P15 P14 P3 P4 P13 P5 P12 P6 P11 P10 P7 P9 VSS OSS_FRAME
**.ends

* expanding   symbol:  OSS_FRAME.sym # of pins=16
** sym_path: /Users/okamura/Dropbox/91_OpenPDK/WorkDir/OSS_FRAME.sym
** sch_path: /Users/okamura/Dropbox/91_OpenPDK/WorkDir/OSS_FRAME.sch
.subckt OSS_FRAME P1 VDD P2 P15 P14 P3 P4 P13 P5 P12 P6 P11 P10 P7 P9 VSS
*.iopin P1
*.iopin P2
*.iopin P3
*.iopin P4
*.iopin P5
*.iopin P6
*.iopin P7
*.iopin VSS
*.iopin VDD
*.iopin P15
*.iopin P14
*.iopin P13
*.iopin P12
*.iopin P11
*.iopin P10
*.iopin P9
x1 VDD P1 VSS OSS_ESD_5V_ANA
x2 VDD VSS OSS_ESD_5V_VDD
x3 VDD VSS OSS_ESD_5V_VSS
x4 VDD P2 VSS OSS_ESD_5V_ANA
x5 VDD P3 VSS OSS_ESD_5V_ANA
x6 VDD P4 VSS OSS_ESD_5V_ANA
x7 VDD P5 VSS OSS_ESD_5V_ANA
x8 VDD P6 VSS OSS_ESD_5V_ANA
x9 VDD P7 VSS OSS_ESD_5V_ANA
x10 VDD P15 VSS OSS_ESD_5V_ANA
x11 VDD P14 VSS OSS_ESD_5V_ANA
x12 VDD P13 VSS OSS_ESD_5V_ANA
x13 VDD P12 VSS OSS_ESD_5V_ANA
x14 VDD P11 VSS OSS_ESD_5V_ANA
x15 VDD P10 VSS OSS_ESD_5V_ANA
x16 VDD P9 VSS OSS_ESD_5V_ANA
.ends

* expanding   symbol:  OSS_ESD_5V_ANA.sym # of pins=4
** sym_path: /Users/okamura/Dropbox/91_OpenPDK/WorkDir/OSS_ESD_5V_ANA.sym
** sch_path: /Users/okamura/Dropbox/91_OpenPDK/WorkDir/OSS_ESD_5V_ANA.sch
.subckt OSS_ESD_5V_ANA VDD PAD VSS
*.iopin PAD
*.iopin VDD
*.iopin VSS
XXM1 PAD VDD VDD VDD MPE w=500u l=2u as=0 ad=0 ps=0 pd=0 nrd=0 nrs=0
XXM2 PAD VSS VSS VSS MNE w=500u l=2u as=0 ad=0 ps=0 pd=0 nrd=0 nrs=0
.ends

* expanding   symbol:  OSS_ESD_5V_VDD.sym # of pins=3
** sym_path: /Users/okamura/Dropbox/91_OpenPDK/WorkDir/OSS_ESD_5V_VDD.sym
** sch_path: /Users/okamura/Dropbox/91_OpenPDK/WorkDir/OSS_ESD_5V_VDD.sch
.subckt OSS_ESD_5V_VDD VDD VSS
*.iopin VDD
*.iopin VSS
XXM1 VDD VDD VDD VDD MPE w=500u l=2u as=0 ad=0 ps=0 pd=0 nrd=0 nrs=0
XXM2 VDD VSS VSS VSS MNE w=500u l=2u as=0 ad=0 ps=0 pd=0 nrd=0 nrs=0
.ends

* expanding   symbol:  OSS_ESD_5V_VSS.sym # of pins=3
** sym_path: /Users/okamura/Dropbox/91_OpenPDK/WorkDir/OSS_ESD_5V_VSS.sym
** sch_path: /Users/okamura/Dropbox/91_OpenPDK/WorkDir/OSS_ESD_5V_VSS.sch
.subckt OSS_ESD_5V_VSS VDD VSS
*.iopin VSS
*.iopin VDD
XXM1 VSS VDD VDD VDD MPE w=500u l=2u as=0 ad=0 ps=0 pd=0 nrd=0 nrs=0
XXM2 VSS VSS VSS VSS MNE w=500u l=2u as=0 ad=0 ps=0 pd=0 nrd=0 nrs=0
.ends

.end
