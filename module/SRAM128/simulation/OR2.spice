** sch_path: /Users/okamura/Dropbox/91_OpenPDK/TR-1um/libs.tech/xschem/IP62_5_stdcell/OR2.sch
.subckt OR2 VDD Y A B GND
*.PININFO A:I B:I Y:O VDD:B GND:B
MM7 net2 B VDD VDD PMOS w=10.2u l=1u
MM2 net1 A net2 VDD PMOS w=10.2u l=1u
MM4 Y net1 VDD VDD PMOS w=10.2u l=1u
MM1 net1 B GND GND NMOS w=3.4u l=1u
MM3 net1 A GND GND NMOS w=3.4u l=1u
MM5 Y net1 GND GND NMOS w=3.4u l=1u
.ends
