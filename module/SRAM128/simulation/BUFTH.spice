** sch_path: /Users/okamura/Dropbox/98_LSI_Design/TR-1um_Async_I2C/LEF/BUFTH.sch
.subckt BUFTH VDD A Y GND
*.PININFO A:I Y:O VDD:B GND:B
MM9 MID A net1 VDD PMOS w=5.1u l=1u
MM2 Y MID VDD VDD PMOS w=10.2u l=1u
MM8 MID A net2 GND NMOS w=3.4u l=1u
MM1 Y MID GND GND NMOS w=3.4u l=1u
MM6 GND MID net1 VDD PMOS w=10.2u l=1u
MM3 VDD MID net2 GND NMOS w=6.8u l=1u
MM5 net2 A GND GND NMOS w=3.4u l=1u
MM4 net1 A VDD VDD PMOS w=5.1u l=1u
.ends
