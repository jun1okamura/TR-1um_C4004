** sch_path: /Users/okamura/Dropbox/98_LSI_Design/TR-1um_Async_I2C/ring_osc/RING_OSC.sch
.subckt RING_OSC OUT OUTD ENB VDD VSS
*.PININFO OUT:O OUTD:O ENB:I VDD:B VSS:B
x1[0] VDD FB R[0] VSS INV_X1
x1[1] VDD R[0] R[1] VSS INV_X1
x1[2] VDD R[1] R[2] VSS INV_X1
x1[3] VDD R[2] R[3] VSS INV_X1
x1[4] VDD R[3] R[4] VSS INV_X1
x1[5] VDD R[4] R[5] VSS INV_X1
x1[6] VDD R[5] R[6] VSS INV_X1
x1[7] VDD R[6] R[7] VSS INV_X1
x1[8] VDD R[7] R[8] VSS INV_X1
x1[9] VDD R[8] R[9] VSS INV_X1
x1[10] VDD R[9] R[10] VSS INV_X1
x1[11] VDD R[10] R[11] VSS INV_X1
x1[12] VDD R[11] R[12] VSS INV_X1
x1[13] VDD R[12] R[13] VSS INV_X1
x1[14] VDD R[13] R[14] VSS INV_X1
x1[15] VDD R[14] R[15] VSS INV_X1
x1[16] VDD R[15] R[16] VSS INV_X1
x1[17] VDD R[16] R[17] VSS INV_X1
x1[18] VDD R[17] R[18] VSS INV_X1
x1[19] VDD R[18] R[19] VSS INV_X1
x1[20] VDD R[19] R[20] VSS INV_X1
x1[21] VDD R[20] R[21] VSS INV_X1
x1[22] VDD R[21] R[22] VSS INV_X1
x1[23] VDD R[22] R[23] VSS INV_X1
x1[24] VDD R[23] R[24] VSS INV_X1
x1[25] VDD R[24] R[25] VSS INV_X1
x1[26] VDD R[25] R[26] VSS INV_X1
x1[27] VDD R[26] R[27] VSS INV_X1
x1[28] VDD R[27] R[28] VSS INV_X1
x1[29] VDD R[28] R[29] VSS INV_X1
x1[30] VDD R[29] R[30] VSS INV_X1
x1[31] VDD R[30] R[31] VSS INV_X1
x1[32] VDD R[31] R[32] VSS INV_X1
x1[33] VDD R[32] R[33] VSS INV_X1
x1[34] VDD R[33] R[34] VSS INV_X1
x1[35] VDD R[34] R[35] VSS INV_X1
x1[36] VDD R[35] R[36] VSS INV_X1
x1[37] VDD R[36] R[37] VSS INV_X1
x1[38] VDD R[37] R[38] VSS INV_X1
x1[39] VDD R[38] R[39] VSS INV_X1
x1[40] VDD R[39] R[40] VSS INV_X1
x1[41] VDD R[40] R[41] VSS INV_X1
x1[42] VDD R[41] R[42] VSS INV_X1
x1[43] VDD R[42] R[43] VSS INV_X1
x1[44] VDD R[43] R[44] VSS INV_X1
x1[45] VDD R[44] R[45] VSS INV_X1
x1[46] VDD R[45] R[46] VSS INV_X1
x1[47] VDD R[46] R[47] VSS INV_X1
x1[48] VDD R[47] R[48] VSS INV_X1
x1[49] VDD R[48] R[49] VSS INV_X1
x1[50] VDD R[49] R[50] VSS INV_X1
x1[51] VDD R[50] R[51] VSS INV_X1
x1[52] VDD R[51] R[52] VSS INV_X1
x1[53] VDD R[52] R[53] VSS INV_X1
x1[54] VDD R[53] R[54] VSS INV_X1
x1[55] VDD R[54] R[55] VSS INV_X1
x1[56] VDD R[55] R[56] VSS INV_X1
x1[57] VDD R[56] R[57] VSS INV_X1
x1[58] VDD R[57] R[58] VSS INV_X1
x1[59] VDD R[58] R[59] VSS INV_X1
x1[60] VDD R[59] R[60] VSS INV_X1
x1[61] VDD R[60] R[61] VSS INV_X1
x1[62] VDD R[61] R[62] VSS INV_X1
x1[63] VDD R[62] R[63] VSS INV_X1
x1[64] VDD R[63] R[64] VSS INV_X1
x1[65] VDD R[64] R[65] VSS INV_X1
x1[66] VDD R[65] R[66] VSS INV_X1
x1[67] VDD R[66] R[67] VSS INV_X1
x1[68] VDD R[67] R[68] VSS INV_X1
x1[69] VDD R[68] R[69] VSS INV_X1
x1[70] VDD R[69] R[70] VSS INV_X1
x1[71] VDD R[70] R[71] VSS INV_X1
x1[72] VDD R[71] R[72] VSS INV_X1
x1[73] VDD R[72] R[73] VSS INV_X1
x1[74] VDD R[73] R[74] VSS INV_X1
x1[75] VDD R[74] R[75] VSS INV_X1
x1[76] VDD R[75] R[76] VSS INV_X1
x1[77] VDD R[76] R[77] VSS INV_X1
x1[78] VDD R[77] R[78] VSS INV_X1
x1[79] VDD R[78] R[79] VSS INV_X1
x1[80] VDD R[79] R[80] VSS INV_X1
x1[81] VDD R[80] R[81] VSS INV_X1
x1[82] VDD R[81] R[82] VSS INV_X1
x1[83] VDD R[82] R[83] VSS INV_X1
x1[84] VDD R[83] R[84] VSS INV_X1
x1[85] VDD R[84] R[85] VSS INV_X1
x1[86] VDD R[85] R[86] VSS INV_X1
x1[87] VDD R[86] R[87] VSS INV_X1
x1[88] VDD R[87] R[88] VSS INV_X1
x1[89] VDD R[88] R[89] VSS INV_X1
x1[90] VDD R[89] R[90] VSS INV_X1
x1[91] VDD R[90] R[91] VSS INV_X1
x1[92] VDD R[91] R[92] VSS INV_X1
x1[93] VDD R[92] R[93] VSS INV_X1
x1[94] VDD R[93] R[94] VSS INV_X1
x1 VDD FB R[94] ENB VSS AND2_X1
x3 VDD FB OUT VSS INV_X1
x2 VDD FD D[94] ENB VSS AND2_X1
x4 VDD FD OUTD VSS INV_X1
x5[0] VDD VSS FILL2
x5[1] VDD VSS FILL2
x5[2] VDD VSS FILL2
x5[3] VDD VSS FILL2
x5[4] VDD VSS FILL2
x5[5] VDD VSS FILL2
x5[6] VDD VSS FILL2
x5[7] VDD VSS FILL2
x5[8] VDD VSS FILL2
x5[9] VDD VSS FILL2
x5[10] VDD VSS FILL2
x5[11] VDD VSS FILL2
x5[12] VDD VSS FILL2
x5[13] VDD VSS FILL2
x5[14] VDD VSS FILL2
x5[15] VDD VSS FILL2
x3[0] VDD VSS FILL2
x3[1] VDD VSS FILL2
x3[2] VDD VSS FILL2
x3[3] VDD VSS FILL2
x3[4] VDD VSS FILL2
x3[5] VDD VSS FILL2
x3[6] VDD VSS FILL2
x3[7] VDD VSS FILL2
x3[8] VDD VSS FILL2
x3[9] VDD VSS FILL2
x3[10] VDD VSS FILL2
x3[11] VDD VSS FILL2
x3[12] VDD VSS FILL2
x3[13] VDD VSS FILL2
x3[14] VDD VSS FILL2
x3[15] VDD VSS FILL2
x3[16] VDD VSS FILL2
x3[17] VDD VSS FILL2
x3[18] VDD VSS FILL2
x3[19] VDD VSS FILL2
x3[20] VDD VSS FILL2
x3[21] VDD VSS FILL2
x3[22] VDD VSS FILL2
x3[23] VDD VSS FILL2
x3[24] VDD VSS FILL2
x3[25] VDD VSS FILL2
x3[26] VDD VSS FILL2
x3[27] VDD VSS FILL2
x3[28] VDD VSS FILL2
x3[29] VDD VSS FILL2
x3[30] VDD VSS FILL2
x3[31] VDD VSS FILL2
x3[32] VDD VSS FILL2
x3[33] VDD VSS FILL2
x3[34] VDD VSS FILL2
x3[35] VDD VSS FILL2
x3[36] VDD VSS FILL2
x3[37] VDD VSS FILL2
x3[38] VDD VSS FILL2
x3[39] VDD VSS FILL2
x3[40] VDD VSS FILL2
x3[41] VDD VSS FILL2
x3[42] VDD VSS FILL2
x3[43] VDD VSS FILL2
x3[44] VDD VSS FILL2
x3[45] VDD VSS FILL2
x3[46] VDD VSS FILL2
x3[47] VDD VSS FILL2
x3[48] VDD VSS FILL2
x3[49] VDD VSS FILL2
x3[50] VDD VSS FILL2
x3[51] VDD VSS FILL2
x3[52] VDD VSS FILL2
x3[53] VDD VSS FILL2
x3[54] VDD VSS FILL2
x3[55] VDD VSS FILL2
x3[56] VDD VSS FILL2
x3[57] VDD VSS FILL2
x3[58] VDD VSS FILL2
x3[59] VDD VSS FILL2
x3[60] VDD VSS FILL2
x3[61] VDD VSS FILL2
x3[62] VDD VSS FILL2
x3[63] VDD VSS FILL2
x3[64] VDD VSS FILL2
x3[65] VDD VSS FILL2
x3[66] VDD VSS FILL2
x3[67] VDD VSS FILL2
x3[68] VDD VSS FILL2
x3[69] VDD VSS FILL2
x3[70] VDD VSS FILL2
x3[71] VDD VSS FILL2
x3[72] VDD VSS FILL2
x3[73] VDD VSS FILL2
x3[74] VDD VSS FILL2
x3[75] VDD VSS FILL2
x3[76] VDD VSS FILL2
x3[77] VDD VSS FILL2
x3[78] VDD VSS FILL2
x3[79] VDD VSS FILL2
x3[80] VDD VSS FILL2
x3[81] VDD VSS FILL2
x3[82] VDD VSS FILL2
x3[83] VDD VSS FILL2
x3[84] VDD VSS FILL2
x3[85] VDD VSS FILL2
x3[86] VDD VSS FILL2
x3[87] VDD VSS FILL2
x3[88] VDD VSS FILL2
x3[89] VDD VSS FILL2
x3[90] VDD VSS FILL2
x3[91] VDD VSS FILL2
x3[92] VDD VSS FILL2
x3[93] VDD VSS FILL2
x3[94] VDD VSS FILL2
x3[95] VDD VSS FILL2
x3[96] VDD VSS FILL2
x3[97] VDD VSS FILL2
x3[98] VDD VSS FILL2
x3[99] VDD VSS FILL2
x3[100] VDD VSS FILL2
x3[101] VDD VSS FILL2
x3[102] VDD VSS FILL2
x3[103] VDD VSS FILL2
x3[104] VDD VSS FILL2
x3[105] VDD VSS FILL2
x3[106] VDD VSS FILL2
x3[107] VDD VSS FILL2
x3[108] VDD VSS FILL2
x3[109] VDD VSS FILL2
x3[110] VDD VSS FILL2
x3[111] VDD VSS FILL2
x3[112] VDD VSS FILL2
x3[113] VDD VSS FILL2
x3[114] VDD VSS FILL2
x3[115] VDD VSS FILL2
x3[116] VDD VSS FILL2
x3[117] VDD VSS FILL2
x3[118] VDD VSS FILL2
x3[119] VDD VSS FILL2
x3[120] VDD VSS FILL2
x3[121] VDD VSS FILL2
x3[122] VDD VSS FILL2
x3[123] VDD VSS FILL2
x3[124] VDD VSS FILL2
x3[125] VDD VSS FILL2
x3[126] VDD VSS FILL2
x3[127] VDD VSS FILL2
x3[128] VDD VSS FILL2
x3[129] VDD VSS FILL2
x3[130] VDD VSS FILL2
x3[131] VDD VSS FILL2
x3[132] VDD VSS FILL2
x3[133] VDD VSS FILL2
x3[134] VDD VSS FILL2
x3[135] VDD VSS FILL2
x3[136] VDD VSS FILL2
x3[137] VDD VSS FILL2
x3[138] VDD VSS FILL2
x3[139] VDD VSS FILL2
x3[140] VDD VSS FILL2
x3[141] VDD VSS FILL2
x3[142] VDD VSS FILL2
x3[143] VDD VSS FILL2
x3[144] VDD VSS FILL2
x3[145] VDD VSS FILL2
x3[146] VDD VSS FILL2
x3[147] VDD VSS FILL2
x3[148] VDD VSS FILL2
x3[149] VDD VSS FILL2
x3[150] VDD VSS FILL2
x3[151] VDD VSS FILL2
x3[152] VDD VSS FILL2
x3[153] VDD VSS FILL2
x3[154] VDD VSS FILL2
x3[155] VDD VSS FILL2
x3[156] VDD VSS FILL2
x3[157] VDD VSS FILL2
x3[158] VDD VSS FILL2
x3[159] VDD VSS FILL2
x3[160] VDD VSS FILL2
x3[161] VDD VSS FILL2
x3[162] VDD VSS FILL2
x3[163] VDD VSS FILL2
x3[164] VDD VSS FILL2
x3[165] VDD VSS FILL2
x3[166] VDD VSS FILL2
x3[167] VDD VSS FILL2
x3[168] VDD VSS FILL2
x3[169] VDD VSS FILL2
x3[170] VDD VSS FILL2
x3[171] VDD VSS FILL2
x3[172] VDD VSS FILL2
x3[173] VDD VSS FILL2
x3[174] VDD VSS FILL2
x3[175] VDD VSS FILL2
x3[176] VDD VSS FILL2
x3[177] VDD VSS FILL2
x3[178] VDD VSS FILL2
x3[179] VDD VSS FILL2
x3[180] VDD VSS FILL2
x3[181] VDD VSS FILL2
x3[182] VDD VSS FILL2
x3[183] VDD VSS FILL2
x3[184] VDD VSS FILL2
x3[185] VDD VSS FILL2
x3[186] VDD VSS FILL2
x3[187] VDD VSS FILL2
x3[188] VDD VSS FILL2
x3[189] VDD VSS FILL2
x54[0] VDD FD D[0] VSS INV3D
x54[1] VDD D[0] D[1] VSS INV3D
x54[2] VDD D[1] D[2] VSS INV3D
x54[3] VDD D[2] D[3] VSS INV3D
x54[4] VDD D[3] D[4] VSS INV3D
x54[5] VDD D[4] D[5] VSS INV3D
x54[6] VDD D[5] D[6] VSS INV3D
x54[7] VDD D[6] D[7] VSS INV3D
x54[8] VDD D[7] D[8] VSS INV3D
x54[9] VDD D[8] D[9] VSS INV3D
x54[10] VDD D[9] D[10] VSS INV3D
x54[11] VDD D[10] D[11] VSS INV3D
x54[12] VDD D[11] D[12] VSS INV3D
x54[13] VDD D[12] D[13] VSS INV3D
x54[14] VDD D[13] D[14] VSS INV3D
x54[15] VDD D[14] D[15] VSS INV3D
x54[16] VDD D[15] D[16] VSS INV3D
x54[17] VDD D[16] D[17] VSS INV3D
x54[18] VDD D[17] D[18] VSS INV3D
x54[19] VDD D[18] D[19] VSS INV3D
x54[20] VDD D[19] D[20] VSS INV3D
x54[21] VDD D[20] D[21] VSS INV3D
x54[22] VDD D[21] D[22] VSS INV3D
x54[23] VDD D[22] D[23] VSS INV3D
x54[24] VDD D[23] D[24] VSS INV3D
x54[25] VDD D[24] D[25] VSS INV3D
x54[26] VDD D[25] D[26] VSS INV3D
x54[27] VDD D[26] D[27] VSS INV3D
x54[28] VDD D[27] D[28] VSS INV3D
x54[29] VDD D[28] D[29] VSS INV3D
x54[30] VDD D[29] D[30] VSS INV3D
x54[31] VDD D[30] D[31] VSS INV3D
x54[32] VDD D[31] D[32] VSS INV3D
x54[33] VDD D[32] D[33] VSS INV3D
x54[34] VDD D[33] D[34] VSS INV3D
x54[35] VDD D[34] D[35] VSS INV3D
x54[36] VDD D[35] D[36] VSS INV3D
x54[37] VDD D[36] D[37] VSS INV3D
x54[38] VDD D[37] D[38] VSS INV3D
x54[39] VDD D[38] D[39] VSS INV3D
x54[40] VDD D[39] D[40] VSS INV3D
x54[41] VDD D[40] D[41] VSS INV3D
x54[42] VDD D[41] D[42] VSS INV3D
x54[43] VDD D[42] D[43] VSS INV3D
x54[44] VDD D[43] D[44] VSS INV3D
x54[45] VDD D[44] D[45] VSS INV3D
x54[46] VDD D[45] D[46] VSS INV3D
x54[47] VDD D[46] D[47] VSS INV3D
x54[48] VDD D[47] D[48] VSS INV3D
x54[49] VDD D[48] D[49] VSS INV3D
x54[50] VDD D[49] D[50] VSS INV3D
x54[51] VDD D[50] D[51] VSS INV3D
x54[52] VDD D[51] D[52] VSS INV3D
x54[53] VDD D[52] D[53] VSS INV3D
x54[54] VDD D[53] D[54] VSS INV3D
x54[55] VDD D[54] D[55] VSS INV3D
x54[56] VDD D[55] D[56] VSS INV3D
x54[57] VDD D[56] D[57] VSS INV3D
x54[58] VDD D[57] D[58] VSS INV3D
x54[59] VDD D[58] D[59] VSS INV3D
x54[60] VDD D[59] D[60] VSS INV3D
x54[61] VDD D[60] D[61] VSS INV3D
x54[62] VDD D[61] D[62] VSS INV3D
x54[63] VDD D[62] D[63] VSS INV3D
x54[64] VDD D[63] D[64] VSS INV3D
x54[65] VDD D[64] D[65] VSS INV3D
x54[66] VDD D[65] D[66] VSS INV3D
x54[67] VDD D[66] D[67] VSS INV3D
x54[68] VDD D[67] D[68] VSS INV3D
x54[69] VDD D[68] D[69] VSS INV3D
x54[70] VDD D[69] D[70] VSS INV3D
x54[71] VDD D[70] D[71] VSS INV3D
x54[72] VDD D[71] D[72] VSS INV3D
x54[73] VDD D[72] D[73] VSS INV3D
x54[74] VDD D[73] D[74] VSS INV3D
x54[75] VDD D[74] D[75] VSS INV3D
x54[76] VDD D[75] D[76] VSS INV3D
x54[77] VDD D[76] D[77] VSS INV3D
x54[78] VDD D[77] D[78] VSS INV3D
x54[79] VDD D[78] D[79] VSS INV3D
x54[80] VDD D[79] D[80] VSS INV3D
x54[81] VDD D[80] D[81] VSS INV3D
x54[82] VDD D[81] D[82] VSS INV3D
x54[83] VDD D[82] D[83] VSS INV3D
x54[84] VDD D[83] D[84] VSS INV3D
x54[85] VDD D[84] D[85] VSS INV3D
x54[86] VDD D[85] D[86] VSS INV3D
x54[87] VDD D[86] D[87] VSS INV3D
x54[88] VDD D[87] D[88] VSS INV3D
x54[89] VDD D[88] D[89] VSS INV3D
x54[90] VDD D[89] D[90] VSS INV3D
x54[91] VDD D[90] D[91] VSS INV3D
x54[92] VDD D[91] D[92] VSS INV3D
x54[93] VDD D[92] D[93] VSS INV3D
x54[94] VDD D[93] D[94] VSS INV3D
.ends

* expanding   symbol:  INV_X1.sym # of pins=4
** sym_path: /Users/okamura/Dropbox/91_OpenPDK/TR-1um/libs.tech/xschem/IP62_5_stdcell/INV_X1.sym
** sch_path: /Users/okamura/Dropbox/91_OpenPDK/TR-1um/libs.tech/xschem/IP62_5_stdcell/INV_X1.sch
.subckt INV_X1 VDD A Y GND
*.PININFO A:I Y:O GND:B VDD:B
MM7 Y A VDD VDD PMOS w=10.2u l=1u
MM2 Y A GND GND NMOS w=3.4u l=1u
.ends

* expanding   symbol:  AND2_X1.sym # of pins=5
** sym_path: /Users/okamura/Dropbox/91_OpenPDK/TR-1um/libs.tech/xschem/IP62_5_stdcell/AND2_X1.sym
** sch_path: /Users/okamura/Dropbox/91_OpenPDK/TR-1um/libs.tech/xschem/IP62_5_stdcell/AND2_X1.sch
.subckt AND2_X1 VDD Y A B GND
*.PININFO Y:O A:I B:I VDD:B GND:B
MM7 net1 B VDD VDD PMOS w=10.2u l=1u
MM1 net1 A VDD VDD PMOS w=10.2u l=1u
MM2 Y net1 VDD VDD PMOS w=10.2u l=1u
MM3 Y net1 GND GND NMOS w=3.4u l=1u
MM4 net1 A net2 GND NMOS w=3.4u l=1u
MM5 net2 B GND GND NMOS w=3.4u l=1u
.ends

* expanding   symbol:  /Users/okamura/Dropbox/98_LSI_Design/TR-1um_Async_I2C/LEF/FILL2.sym # of pins=2
** sym_path: /Users/okamura/Dropbox/98_LSI_Design/TR-1um_Async_I2C/LEF/FILL2.sym
** sch_path: /Users/okamura/Dropbox/98_LSI_Design/TR-1um_Async_I2C/LEF/FILL2.sch
.subckt FILL2 VDD GND
*.PININFO GND:B VDD:B
MM7 VDD GND VDD VDD PMOS w=21.2u l=3.2u
MM2 GND VDD GND GND NMOS w=13.1u l=3.2u
.ends

* expanding   symbol:  INV3D.sym # of pins=4
** sym_path: /Users/okamura/Dropbox/98_LSI_Design/TR-1um_Async_I2C/ring_osc/INV3D.sym
** sch_path: /Users/okamura/Dropbox/98_LSI_Design/TR-1um_Async_I2C/ring_osc/INV3D.sch
.subckt INV3D VDD A Y GND
*.PININFO A:I Y:O GND:B VDD:B
MM7 Y A VDD VDD PMOS w=10.2u l=1u
MM2 Y A GND GND NMOS w=3.4u l=1u
.ends
