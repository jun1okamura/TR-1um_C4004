** sch_path: /Users/okamura/Dropbox/98_LSI_Design/TR-1um_Async_I2C/ring_osc/INV3D.sch
.subckt INV3D VDD A Y GND
*.PININFO A:I Y:O GND:B VDD:B
MM7 Y A VDD VDD PMOS w=10.2u l=1u
MM2 Y A GND GND NMOS w=3.4u l=1u
.ends
