** sch_path: /Users/okamura/Dropbox/91_OpenPDK/TR-1um/libs.tech/xschem/IP62_5_stdcell/NOR2.sch
.subckt NOR2 VDD Y A B GND
*.PININFO A:I B:I Y:O VDD:B GND:B
MM7 net1 A VDD VDD PMOS w=10.2u l=1u
MM1 Y B net1 VDD PMOS w=10.2u l=1u
MM2 Y A GND GND NMOS w=3.4u l=1u
MM3 Y B GND GND NMOS w=3.4u l=1u
.ends
