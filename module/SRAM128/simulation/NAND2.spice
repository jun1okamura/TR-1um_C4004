** sch_path: /Users/okamura/Dropbox/91_OpenPDK/TR-1um/libs.tech/xschem/IP62_5_stdcell/NAND2.sch
.subckt NAND2 VDD Y A B GND
*.PININFO B:I A:I Y:O GND:B VDD:B
MM7 Y A VDD VDD PMOS w=10.2u l=1u
MM1 Y B VDD VDD PMOS w=10.2u l=1u
MM2 Y B net1 GND NMOS w=3.4u l=1u
MM3 net1 A GND GND NMOS w=3.4u l=1u
.ends
