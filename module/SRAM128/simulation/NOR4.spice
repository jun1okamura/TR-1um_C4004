** sch_path: /Users/okamura/Dropbox/91_OpenPDK/TR-1um/libs.tech/xschem/IP62_5_stdcell/NOR4.sch
.subckt NOR4 A B C D VDD Y GND
*.PININFO A:I B:I Y:O VDD:B GND:B C:I D:I
MM8 net1 B VDD VDD PMOS w=10.2u l=1u
MM2 net2 A net1 VDD PMOS w=10.2u l=1u
MM3 net3 C net2 VDD PMOS w=10.2u l=1u
MM6 Y D net3 VDD PMOS w=10.2u l=1u
MM9 Y D GND GND NMOS w=3.4u l=1u
MM1 Y B GND GND NMOS w=3.4u l=1u
MM4 Y C GND GND NMOS w=3.4u l=1u
MM5 Y A GND GND NMOS w=3.4u l=1u
.ends
