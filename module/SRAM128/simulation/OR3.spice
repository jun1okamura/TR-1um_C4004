** sch_path: /Users/okamura/Dropbox/91_OpenPDK/TR-1um/libs.tech/xschem/IP62_5_stdcell/OR3.sch
.subckt OR3 C VDD Y A B GND
*.PININFO A:I B:I Y:O VDD:B GND:B C:I
MM8 net1 B VDD VDD PMOS w=10.2u l=1u
MM2 net2 A net1 VDD PMOS w=10.2u l=1u
MM3 net3 C net2 VDD PMOS w=10.2u l=1u
MM7 Y net3 VDD VDD PMOS w=10.2u l=1u
MM9 Y net3 GND GND NMOS w=3.4u l=1u
MM1 net3 C GND GND NMOS w=3.4u l=1u
MM4 net3 A GND GND NMOS w=3.4u l=1u
MM5 net3 B GND GND NMOS w=3.4u l=1u
.ends
