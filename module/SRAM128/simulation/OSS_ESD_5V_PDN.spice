** sch_path: /Users/okamura/Dropbox/91_OpenPDK/TR-1um/libs.tech/xschem/TR-1um_frame/OSS_ESD_5V_PDN.sch
.subckt OSS_ESD_5V_PDN VDD PAD VSS ENB OUT
*.PININFO PAD:B VDD:B VSS:B ENB:I OUT:I
MXM1 PAD VDD VDD VDD PMOS w=300u l=2u
MXM2 PAD NG VSS VSS NMOSE w=200u l=2u
MXM3 PG PGG VDD VDD PMOS w=20.8u l=1u
MXM4 PG PGG VSS VSS NMOS w=6.8u l=1u
MXM5 PAD VDD VDD VDD PMOS w=200u l=2u
MXM6 PAD VSS VSS VSS NMOSE w=300u l=2u
MXM7 NG NGG VDD VDD PMOS w=20.8u l=1u
MXM8 NG NGG VSS VSS NMOS w=6.8u l=1u
MXM9 PGG ENB_ net1 VDD PMOS w=10.4u l=1u
MXM10 net1 OUT VDD VDD PMOS w=10.4u l=1u
MXM11 PGG OUT VSS VSS NMOS w=3.4u l=1u
MXM12 PGG ENB_ VSS VSS NMOS w=3.4u l=1u
MXM13 NGG OUT VDD VDD PMOS w=5.2u l=1u
MXM14 NGG ENB VDD VDD PMOS w=5.2u l=1u
MXM15 NGG ENB net2 VSS NMOS w=3.4u l=1u
MXM16 net2 OUT VSS VSS NMOS w=3.4u l=1u
MXM17 ENB_ ENB VDD VDD PMOS w=5.2u l=1u
MXM18 ENB_ ENB VSS VSS NMOS w=3.4u l=1u
DD1 VSS ENB DN A=12.96p P=14.4u
DD2 OUT VDD DP A=12.96p P=14.4u
.ends
